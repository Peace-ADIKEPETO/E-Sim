RC Low-Pass Filter
V1 1 0 AC 1
R1 1 2 1000
C1 2 0 1u
.ac dec 10 1 100k
.end
