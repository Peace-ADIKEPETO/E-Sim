Simple DC Circuit
V1 1 0 dc 5
R1 2 1 1000
C1 2 0 1u IC=0
.tran 1u 3m UIC
.end
